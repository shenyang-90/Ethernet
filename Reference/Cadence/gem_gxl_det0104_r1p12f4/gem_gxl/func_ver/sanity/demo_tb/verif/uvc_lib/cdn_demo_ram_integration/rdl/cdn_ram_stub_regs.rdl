// ******************************************************************************
// ------------------------------------------------------------------------------
//
//             CADENCE                    Copyright (c) 2017
//                                        Cadence Design Systems, Inc.
//                                        All rights reserved.
//
//   This work may not be copied, modified, re-published, uploaded, executed, or
//   distributed in any way, in any medium, whether in whole or in part, without
//   prior written permission from Cadence Design Systems, Inc.
// ------------------------------------------------------------------------------
//
//    Module Name    : RAM stub  register addressmap
//
//    Filename       : $RCSfile: $
//
//   Author          : bsidelko@cadence.com
//
//    Date           : $Date: $
//
//    File ID        : $Revision: $
//
//   Design version : $Name:  $
// ------------------------------------------------------------------------------
//   Description:
//
//
//
// ------------------------------------------------------------------------------

//`include "cdn_ram_stub_config.rdl"
//`include "cdn_ram_stub.rdl"

<% %cfg = (
    'CDN_NUM_OF_SRAM_BLOCKS' => 32,
    'CDN_NUM_OF_DP1R1W_BLOCKS' => 32,
    'CDN_NUM_OF_DP2R2W_BLOCKS' => 32,
    'CDN_NUM_OF_RF_BLOCKS' => 32,
    'CDN_NUM_OF_SRAM_BE_BLOCKS' => 32,
    'CDN_NUM_OF_DP1R1W_BE_BLOCKS' => 32,
    'CDN_NUM_OF_DP2R2W_BE_BLOCKS' => 32,
    'CDN_NUM_OF_RF_BE_BLOCKS' => 32);
%>



reg APB_BANK_REG {
    name = "APB_BANK_REGISTER";
    desc = "APB control and status register which controls the following functions:
            - RAM test algorithm to run
            - Start trigger
            - Reset/scrub RAM contents
            - Running/Done status flag
            - Pass/Fail status flag
            - Clear Status";
    regwidth=32;
    //
    // RSVD
    field {
      name="Rsvd";
      desc="Reserved: Reserved for future RO implementations. Registers or memory that shall be treated as read-only by system software. Rsvd registers shall return zero when read. Software shall ignore the value read from these bits.
            Note: At present the fields are implemented as RO.";
      sw = r;            //R
      hw = rw;
      reset = 0;
    } RSVD [31:8];
    //
    field {
      name = "RAM_Algorithm_Unique_data";
      desc = "RAM test algorithm to run - Unique data to each location then read back. PURPOSE: check for sizing, aliasing and correct address and control strobe connection.";
      fieldwidth = 1;
      hw = rw;
      sw = rw;            //RW
      reset = 1'b0;
    } RAM_ALGORITHM_DATA [7:7];
    //
    field {
      name = "RAM_Algorithm_Walking_1";
      desc = "RAM test algorithm to run - Walking 1 test. PURPOSE: check data path connection.";
      fieldwidth = 1;
      hw = rw;
      sw = rw;            //RW
      reset = 1'b0;
    } RAM_ALGORITHM_1 [6:6];
    //
    field {
      name = "RAM_Algorithm_Walking_0";
      desc = "RAM test algorithm to run - Walking 0 test. PURPOSE: check data path connection.";
      fieldwidth = 1;
      hw = rw;
      sw = rw;            //RW
      reset = 1'b0;
    } RAM_ALGORITHM_0 [5:5];
    //
    field {
      name = "Start_trigger";
      desc = "Write 1 to Start testing.
              Always read as 0.";
      fieldwidth = 1;
      hw = rw;
      sw = rw;            //RW
      reset=0;
    } START_TRIGGER [4:4];
    //
    field {
      name = "Reset_scrub_RAM";
      desc = "Write 1 to Reset/scrub RAM content.
              Always read as 0.";
      fieldwidth = 1;
      hw = rw;
      sw = rw;            //RW
      reset=0;
    } RESET_SCRUB_RAM [3:3];
    //
    field {
      name = "Running_Done_status_flag";
      desc = "Running/Done status flag:
              - 1'b0 : Running
              - 1'b1 : Done";
      fieldwidth = 1;
      hw = rw;
      sw = r;             //R
      reset=0;
    } RUNNING_DONE_STATUS_FLAG [2:2];
    //
    field {
      name = "Pass_Fail_status_flag";
      desc = "Pass/Fail status flag:
              - 1'b0 : Fail
              - 1'b1 : Pass";
      fieldwidth = 1;
      hw = rw;
      sw = r;             //R
      reset=0;
    } PASS_FAIL_STATUS_FLAG [1:1];
    //
    field {
      name = "Clear_Status";
      desc = "Write 1 to Clear 'Running/Done' and 'Pass/Fail' status flags.
              Always read as 0.";
      fieldwidth = 1;
      hw = rw;
      sw = r;             //R
      reset=0;
    } CLEAR_STATUS [0:0];
  //
};  //APB_BANK_REG;

reg NUM_OF_RAM_REG {
    name = "NUM_OF_RAM_REGISTER";
    desc = "Number of RAM blocks of considered type";
    regwidth=32;
    //
    // RSVD2
    field {
       name="Rsvd";
       desc="Reserved: Reserved for future RO implementations. Registers or memory that shall be treated as read-only by system software. Rsvd registers shall return zero when read. Software shall ignore the value read from these bits.
             Note: At present the fields are implemented as RO.";
       hw = rw;
       sw = r;            //R
       reset = 0;
    } RSVD2 [31:4];
    //
    field {
      name = "NUMBER_OF_RAM";
      desc = "Number of RAM blocks of considered type.";
      fieldwidth = 4;
      hw = rw;
      sw = r;             //R
      reset = 4'h0;
    } NUM_OF_RAM [3:0];
  //
};  //NUM_OF_RAM_REG;



// ------------------------------------------------------------------
// Master APB Bank Registers
// ------------------------------------------------------------------
addrmap master_apb_register_block_type {
    name = "MASTER APB Register Block";
    desc = "MASTER APB Bank - confrol and status registers";
    // accesswidth=32;
    APB_BANK_REG    MASTER_CTRL_REG      @0x0000;

    NUM_OF_RAM_REG  NUM_OF_SRAM          @0x0004;
    NUM_OF_RAM_REG  NUM_OF_DP1R1W        @0x0008;
    NUM_OF_RAM_REG  NUM_OF_DP2R2W        @0x000C;
    NUM_OF_RAM_REG  NUM_OF_RF            @0x0010;

    NUM_OF_RAM_REG  NUM_OF_SRAM_BE       @0x0014;
    NUM_OF_RAM_REG  NUM_OF_DP1R1W_BE     @0x0018;
    NUM_OF_RAM_REG  NUM_OF_DP2R2W_BE     @0x001C;
    NUM_OF_RAM_REG  NUM_OF_RF_BE         @0x0020;
};

// ------------------------------------------------------------------
// Test Function APB Bank Registers
// ------------------------------------------------------------------
// naming convention: RAMtype_CTRL_REG_BlockNumber  @address
// ------------------------------------------------------------------
addrmap sram_test_function_register_block_type {
    name = "Test Function APB Register Block";
    desc = "Test Function APB Bank - confrol and status registers";
    // accesswidth=32;
    <% for (my $block_idx=0; $block_idx<$cfg{'CDN_NUM_OF_SRAM_BLOCKS'}; $block_idx++) { %>
      <% my $block_base_address = ($block_idx*0x04); %>
    APB_BANK_REG  SRAM_CTRL_REG<%=$block_idx%>  @<%=sprintf("0x%lx",($block_base_address))%>;
    <% } %>
};
addrmap dp1r1w_test_function_register_block_type {
    name = "Test Function APB Register Block";
    desc = "Test Function APB Bank - confrol and status registers";
    // accesswidth=32;
    <% for (my $block_idx=0; $block_idx<$cfg{'CDN_NUM_OF_DP1R1W_BLOCKS'}; $block_idx++) { %>
      <% my $block_base_address = ($block_idx*0x04); %>
    APB_BANK_REG  DP1R1W_CTRL_REG<%=$block_idx%>  @<%=sprintf("0x%lx",($block_base_address))%>;
    <% } %>
};
addrmap dp2r2w_test_function_register_block_type {
    name = "Test Function APB Register Block";
    desc = "Test Function APB Bank - confrol and status registers";
    // accesswidth=32;
    <% for (my $block_idx=0; $block_idx<$cfg{'CDN_NUM_OF_DP2R2W_BLOCKS'}; $block_idx++) { %>
      <% my $block_base_address = ($block_idx*0x04); %>
    APB_BANK_REG  DP2R2W_CTRL_REG<%=$block_idx%>  @<%=sprintf("0x%lx",($block_base_address))%>;
    <% } %>
};
addrmap rf_test_function_register_block_type {
    name = "Test Function APB Register Block";
    desc = "Test Function APB Bank - confrol and status registers";
    // accesswidth=32;
    <% for (my $block_idx=0; $block_idx<$cfg{'CDN_NUM_OF_RF_BLOCKS'}; $block_idx++) { %>
      <% my $block_base_address = ($block_idx*0x04); %>
    APB_BANK_REG  RF_CTRL_REG<%=$block_idx%>  @<%=sprintf("0x%lx",($block_base_address))%>;
    <% } %>
};


addrmap sram_be_test_function_register_block_type {
    name = "Test Function APB Register Block";
    desc = "Test Function APB Bank - confrol and status registers";
    // accesswidth=32;
    <% for (my $block_idx=0; $block_idx<$cfg{'CDN_NUM_OF_SRAM_BE_BLOCKS'}; $block_idx++) { %>
      <% my $block_base_address = ($block_idx*0x04); %>
    APB_BANK_REG  SRAM_BE_CTRL_REG<%=$block_idx%>  @<%=sprintf("0x%lx",($block_base_address))%>;
    <% } %>
};
addrmap dp1r1w_be_test_function_register_block_type {
    name = "Test Function APB Register Block";
    desc = "Test Function APB Bank - confrol and status registers";
    // accesswidth=32;
    <% for (my $block_idx=0; $block_idx<$cfg{'CDN_NUM_OF_DP1R1W_BE_BLOCKS'}; $block_idx++) { %>
      <% my $block_base_address = ($block_idx*0x04); %>
    APB_BANK_REG  DP1R1W_BE_CTRL_REG<%=$block_idx%>  @<%=sprintf("0x%lx",($block_base_address))%>;
    <% } %>
};
addrmap dp2r2w_be_test_function_register_block_type {
    name = "Test Function APB Register Block";
    desc = "Test Function APB Bank - confrol and status registers";
    // accesswidth=32;
    <% for (my $block_idx=0; $block_idx<$cfg{'CDN_NUM_OF_DP2R2W_BE_BLOCKS'}; $block_idx++) { %>
      <% my $block_base_address = ($block_idx*0x04); %>
    APB_BANK_REG  DP2R2W_BE_CTRL_REG<%=$block_idx%>  @<%=sprintf("0x%lx",($block_base_address))%>;
    <% } %>
};
addrmap rf_be_test_function_register_block_type {
    name = "Test Function APB Register Block";
    desc = "Test Function APB Bank - confrol and status registers";
    // accesswidth=32;
    <% for (my $block_idx=0; $block_idx<$cfg{'CDN_NUM_OF_RF_BE_BLOCKS'}; $block_idx++) { %>
      <% my $block_base_address = ($block_idx*0x04); %>
    APB_BANK_REG  RF_BE_CTRL_REG<%=$block_idx%>  @<%=sprintf("0x%lx",($block_base_address))%>;
    <% } %>
};

